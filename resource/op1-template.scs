subckt op B INP INN O VDD VSS
    MNCM1R  (B  B   VSS VSS) %NMOS% m=Mcm11 w=Wcm1 l=Lcm1 %DERIVED%
    MNCM1A  (CM B   VSS VSS) %NMOS% m=Mcm12 w=Wcm1 l=Lcm1 %DERIVED%
    MNCM1B  (O  B   VSS VSS) %NMOS% m=Mcm13 w=Wcm1 l=Lcm1 %DERIVED%
    MND1A   (Y  INP CM  VSS) %NMOS% m=Md w=Wd l=Ld %DERIVED%
    MND1B   (X  INN CM  VSS) %NMOS% m=Md w=Wd l=Ld %DERIVED%
    MPCM2R  (X  X   VDD VDD) %PMOS% m=Mcm21 w=Wcm2 l=Lcm2 %DERIVED%
    MPCM2A  (Y  X   VDD VDD) %PMOS% m=Mcm22 w=Wcm2 l=Lcm2 %DERIVED%
    MPCS1   (O  Y   VDD VDD) %PMOS% m=Mcs w=Wcs l=Lcs %DERIVED%
    C0      (O  A)           %CAP%  area=Wcap*Wcap m=Mcap %DERIVED%         // perimeter=2*(Wcap+Wcap) par1=Mcap
    R0      (A  Y   VSS)     %RES%  %DERIVED% l=Lres w=Wres m=1 %DERIVED%   // pm=-1 par1=(1)
ends op
