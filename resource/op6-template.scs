subckt op B INP INN O VDD VSS
    MNCM11 (B  B   VSS VSS) %NMOS% m=Mcm11 w=Wcm1 l=Lcm1 %NDERIVED%
    MNCM12 (CM B   VSS VSS) %NMOS% m=Mcm12 w=Wcm1 l=Lcm1 %NDERIVED%
    MNCM13 (O  B   VSS VSS) %NMOS% m=Mcm13 w=Wcm1 l=Lcm1 %NDERIVED%
    MND11  (Y  INP CM  VSS) %NMOS% m=Md w=Wd l=Ld %NDERIVED%
    MND12  (X  INN CM  VSS) %NMOS% m=Md w=Wd l=Ld %NDERIVED%
    MPCM21 (X  X   VDD VDD) %PMOS% m=Mcm21 w=Wcm2 l=Lcm2 %PDERIVED%
    MPCM22 (Y  X   VDD VDD) %PMOS% m=Mcm22 w=Wcm2 l=Lcm2 %PDERIVED%
    MPC1   (O  A   O   O)   %PMOS% m=Mc1 w=Wc1 l=Lc1 %PDERIVED%
    MPR1   (A  VSS Y   VDD) %PMOS% m=Mr1 w=Wr1 l=Lr1 %PDERIVED%
    MPCS   (O  Y   VDD VDD) %PMOS% m=Mcs w=Wcs l=Lcs %PDERIVED%
ends op
