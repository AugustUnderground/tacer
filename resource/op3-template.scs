subckt op B INP INN O VDD VSS
    MNCM31  (Z  Z   VSS VSS) %NMOS% m=Mcm31 w=Wcm3 l=Lcm3 %DERIVED%
    MNCM32  (O  Z   VSS VSS) %NMOS% m=Mcm32 w=Wcm3 l=Lcm3 %DERIVED%
    MND12   (X  INP CM  VSS) %NMOS% m=Md w=Wd l=Wd %DERIVED%
    MND11   (Y  INN CM  VSS) %NMOS% m=Md w=Wd l=Wd %DERIVED%
    MNCM11  (B  B   VSS VSS) %NMOS% m=Mcm11 w=Wcm1 l=Lcm1 %DERIVED%
    MNCM12  (CM B   VSS VSS) %NMOS% m=Mcm12 w=Wcm1 l=Lcm1 %DERIVED%
    MPCM222 (Z  Y   VDD VDD) %PMOS% m=Mcm222 w=Wcm2 l=Lcm2 %DERIVED%
    MPCM221 (Y  Y   VDD VDD) %PMOS% m=Mcm2x1 w=Wcm2 l=Lcm2 %DERIVED%
    MPCM212 (O  X   VDD VDD) %PMOS% m=Mcm212 w=Wcm2 l=Lcm2 %DERIVED%
    MPCM211 (X  X   VDD VDD) %PMOS% m=Mcm2x1 w=Wcm2 l=Lcm2 %DERIVED%
ends op
