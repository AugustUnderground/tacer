subckt op B INP INN O VDD VSS
    MND11  (V  INN CM  VSS) %NMOS% m=Md1 w=Wd1 l=Ld1 %NDERIVED%
    MND12  (W  INP CM  VSS) %NMOS% m=Md1 w=Wd1 l=Ld1 %NDERIVED%
    MNCM11 (Y  X   VSS VSS) %NMOS% m=Mcm1 w=Wcm1 l=Lcm1 %NDERIVED%
    MNCM12 (Z  X   VSS VSS) %NMOS% m=Mcm1 w=Wcm1 l=Lcm1 %NDERIVED%
    MPCM21 (X  S   W   VDD) %PMOS% m=Mcm2 w=Wcm2 l=Lcm2 %PDERVIED%
    MPCM22 (O  S   V   VDD) %PMOS% m=Mcm2 w=Wcm2 l=Lcm2 %PDERVIED%
    MNCM41 (B  B   VSS VSS) %NMOS% m=Mcm41 w=Wcm4 l=Lcm4 %NDERIVED%
    MNCM42 (U  B   VSS VSS) %NMOS% m=Mcm42 w=Wcm4 l=Lcm4 %NDERIVED%
    MNCM43 (CM B   VSS VSS) %NMOS% m=Mcm43 w=Wcm4 l=Lcm4 %NDERIVED%
    MNCM44 (S  B   VSS VSS) %NMOS% m=Mcm44 w=Wcm4 l=Lcm4 %NDERIVED%
    MPCM31 (U  U   VDD VDD) %PMOS% m=Mcm31 w=Wcm3 l=Lcm3 %PDERVIED%
    MPCM32 (T  U   VDD VDD) %PMOS% m=Mcm32 w=Wcm3 l=Lcm3 %PDERVIED%
    MPCM33 (W  U   VDD VDD) %PMOS% m=Mcm33 w=Wcm3 l=Lcm3 %PDERVIED%
    MPCM34 (V  U   VDD VDD) %PMOS% m=Mcm34 w=Wcm3 l=Lcm3 %PDERVIED%
    MNLS12 (O  T   Z   VSS) %NMOS% m=Mls1 w=Wls1 l=Lls1 %NDERIVED%
    MNLS11 (X  T   Y   VSS) %NMOS% m=Mls1 w=Wls1 l=Lls1 %NDERIVED%
    MNR1   (T  T   VSS VSS) %NMOS% m=1 w=Wr1 l=Lr1 %NDERIVED%
    MPR2   (S  S   VDD VDD) %PMOS% m=1 w=Wr2 l=Lr2 %PDERVIED%
ends op
